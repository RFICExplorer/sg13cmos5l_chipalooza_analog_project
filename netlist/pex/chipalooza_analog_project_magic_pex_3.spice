* PEX produced on Wed Aug 26 05:12:41 PM CEST 2026 using /foss/tools/sak/sak-pex.sh with m=3 and s=1 (extresist threshold=10000 mOhm, minres=1000 mOhm, mindelay=1 ps)
* NGSPICE file created from chipalooza_analog_project_pex.ext - technology: ihp-sg13cmos5l

.subckt chipalooza_analog_project_pex VPWR VAPWR VGND rst_n clk ena uio_in[7]
+ uio_in[6] uio_in[5] uio_in[4] uio_in[3] uio_in[2] uio_in[1] uio_in[0] ui_in[7]
+ ui_in[6] ui_in[5] ui_in[4] ui_in[3] ui_in[2] ui_in[1] ui_in[0] uio_oe[7]
+ uio_oe[6] uio_oe[5] uio_oe[4] uio_oe[3] uio_oe[2] uio_oe[1] uio_oe[0]
+ uio_out[7] uio_out[6] uio_out[5] uio_out[4] uio_out[3] uio_out[2] uio_out[1]
+ uio_out[0] uo_out[7] uo_out[6] uo_out[5] uo_out[4] uo_out[3] uo_out[2]
+ uo_out[1] uo_out[0] analog_2 analog_1 analog_0
X0 VAPWR VAPWR VAPWR VAPWR sg13_lv_pmos ad=1.14p pd=6.38u as=0.28875n ps=0.61464m w=6u l=1u
X1 VGND.t38 VGND.t35 VGND.t37 VGND.t36 sg13_lv_nmos ad=0.34p pd=2.68u as=0 ps=0 w=1u l=1u
X2 analog_1 analog_0 VGND.t5 VGND.t4 sg13_lv_nmos ad=0.19p pd=1.38u as=0.19p ps=1.38u w=1u l=1u
X3 analog_1 analog_0 VAPWR VAPWR sg13_lv_pmos ad=1.14p pd=6.38u as=1.14p ps=6.38u w=6u l=1u
X4 VAPWR ui_in[0].t1 analog_2 VAPWR sg13_lv_pmos ad=1.14p pd=6.38u as=1.14p ps=6.38u w=6u l=1u
X5 VAPWR analog_0 analog_1 VAPWR sg13_lv_pmos ad=1.14p pd=6.38u as=1.14p ps=6.38u w=6u l=1u
X6 analog_1 analog_0 VGND.t7 VGND.t8 sg13_lv_nmos ad=0.19p pd=1.38u as=0.19p ps=1.38u w=1u l=1u
X7 VAPWR analog_0 analog_1 VAPWR sg13_lv_pmos ad=1.14p pd=6.38u as=1.14p ps=6.38u w=6u l=1u
X8 VAPWR analog_0 analog_1 VAPWR sg13_lv_pmos ad=1.14p pd=6.38u as=1.14p ps=6.38u w=6u l=1u
X9 VGND.t13 analog_0 analog_1 VGND.t12 sg13_lv_nmos ad=0.19p pd=1.38u as=0.19p ps=1.38u w=1u l=1u
X10 VAPWR analog_0 analog_1 VAPWR sg13_lv_pmos ad=1.14p pd=6.38u as=1.14p ps=6.38u w=6u l=1u
X11 analog_1 analog_0 VAPWR VAPWR sg13_lv_pmos ad=1.14p pd=6.38u as=1.14p ps=6.38u w=6u l=1u
X12 analog_2 ui_in[0].t1 VAPWR VAPWR sg13_lv_pmos ad=1.14p pd=6.38u as=1.14p ps=6.38u w=6u l=1u
X13 VGND.t10 analog_0 analog_1 VGND.t9 sg13_lv_nmos ad=0.19p pd=1.38u as=0.19p ps=1.38u w=1u l=1u
X14 VGND.t16 analog_0 analog_1 VGND.t15 sg13_lv_nmos ad=0.19p pd=1.38u as=0.19p ps=1.38u w=1u l=1u
X15 analog_1 analog_0 VAPWR VAPWR sg13_lv_pmos ad=1.14p pd=6.38u as=1.14p ps=6.38u w=6u l=1u
X16 analog_2 ui_in[0].t1 VAPWR VAPWR sg13_lv_pmos ad=1.14p pd=6.38u as=1.14p ps=6.38u w=6u l=1u
X17 VAPWR analog_0 analog_1 VAPWR sg13_lv_pmos ad=1.14p pd=6.38u as=1.14p ps=6.38u w=6u l=1u
X18 VAPWR ui_in[0].t1 analog_2 VAPWR sg13_lv_pmos ad=1.14p pd=6.38u as=1.14p ps=6.38u w=6u l=1u
X19 VGND.t19 analog_0 analog_1 VGND.t18 sg13_lv_nmos ad=0.19p pd=1.38u as=0.19p ps=1.38u w=1u l=1u
X20 analog_1 analog_0 VGND.t25 VGND.t26 sg13_lv_nmos ad=0.19p pd=1.38u as=0.19p ps=1.38u w=1u l=1u
X21 analog_2 ui_in[0].t1 VAPWR VAPWR sg13_lv_pmos ad=1.14p pd=6.38u as=1.14p ps=6.38u w=6u l=1u
X22 VGND.t42 ui_in[0].t0 analog_2 VGND.t33 sg13_lv_nmos ad=0.19p pd=1.38u as=0.19p ps=1.38u w=1u l=1u
X23 analog_1 analog_0 VGND.t22 VGND.t23 sg13_lv_nmos ad=0.19p pd=1.38u as=0.19p ps=1.38u w=1u l=1u
X24 VAPWR analog_0 analog_1 VAPWR sg13_lv_pmos ad=1.14p pd=6.38u as=1.14p ps=6.38u w=6u l=1u
X25 VAPWR ui_in[0].t1 analog_2 VAPWR sg13_lv_pmos ad=1.14p pd=6.38u as=1.14p ps=6.38u w=6u l=1u
X26 analog_2 ui_in[0].t1 VAPWR VAPWR sg13_lv_pmos ad=1.14p pd=6.38u as=1.14p ps=6.38u w=6u l=1u
X27 analog_2 ui_in[0].t0 VGND.t37 VGND.t4 sg13_lv_nmos ad=0.19p pd=1.38u as=0.19p ps=1.38u w=1u l=1u
X28 VGND.t28 analog_0 analog_1 VGND.t27 sg13_lv_nmos ad=0.19p pd=1.38u as=0.19p ps=1.38u w=1u l=1u
X29 VAPWR VAPWR VAPWR VAPWR sg13_lv_pmos ad=1.14p pd=6.38u as=0 ps=0 w=6u l=1u
X30 analog_2 ui_in[0].t1 VAPWR VAPWR sg13_lv_pmos ad=1.14p pd=6.38u as=1.14p ps=6.38u w=6u l=1u
X31 analog_2 ui_in[0].t1 VAPWR VAPWR sg13_lv_pmos ad=1.14p pd=6.38u as=1.14p ps=6.38u w=6u l=1u
X32 VAPWR VAPWR VAPWR VAPWR sg13_lv_pmos ad=2.04p pd=12.68u as=0 ps=0 w=6u l=1u
X33 VGND.t31 analog_0 analog_1 VGND.t30 sg13_lv_nmos ad=0.19p pd=1.38u as=0.19p ps=1.38u w=1u l=1u
X34 VAPWR analog_0 analog_1 VAPWR sg13_lv_pmos ad=1.14p pd=6.38u as=1.14p ps=6.38u w=6u l=1u
X35 analog_2 ui_in[0].t0 VGND.t49 VGND.t8 sg13_lv_nmos ad=0.19p pd=1.38u as=0.19p ps=1.38u w=1u l=1u
X36 VGND.t34 VGND.t46 VGND.t47 VGND.t40 sg13_lv_nmos ad=0.19p pd=1.38u as=0 ps=0 w=1u l=1u
X37 VGND.t1 VPWR VGND.t1 VGND.t0 sg13_lv_pmos ad=3.4p pd=20.68u as=0 ps=0 w=10u l=10u
X38 VGND.t53 ui_in[0].t0 analog_2 VGND.t12 sg13_lv_nmos ad=0.19p pd=1.38u as=0.19p ps=1.38u w=1u l=1u
X39 VGND.t7 analog_0 analog_1 VGND.t6 sg13_lv_nmos ad=0.19p pd=1.38u as=0.19p ps=1.38u w=1u l=1u
X40 VGND.t51 ui_in[0].t0 analog_2 VGND.t9 sg13_lv_nmos ad=0.19p pd=1.38u as=0.19p ps=1.38u w=1u l=1u
X41 VGND.t55 ui_in[0].t0 analog_2 VGND.t15 sg13_lv_nmos ad=0.19p pd=1.38u as=0.19p ps=1.38u w=1u l=1u
X42 analog_1 analog_0 VAPWR VAPWR sg13_lv_pmos ad=1.14p pd=6.38u as=1.14p ps=6.38u w=6u l=1u
X43 analog_1 analog_0 VAPWR VAPWR sg13_lv_pmos ad=1.14p pd=6.38u as=1.14p ps=6.38u w=6u l=1u
X44 VGND.t57 ui_in[0].t0 analog_2 VGND.t18 sg13_lv_nmos ad=0.19p pd=1.38u as=0.19p ps=1.38u w=1u l=1u
X45 analog_2 ui_in[0].t0 VGND.t61 VGND.t26 sg13_lv_nmos ad=0.19p pd=1.38u as=0.19p ps=1.38u w=1u l=1u
X46 analog_1 analog_0 VGND.t13 VGND.t14 sg13_lv_nmos ad=0.19p pd=1.38u as=0.19p ps=1.38u w=1u l=1u
X47 VAPWR analog_0 analog_1 VAPWR sg13_lv_pmos ad=1.14p pd=6.38u as=1.14p ps=6.38u w=6u l=1u
X48 analog_2 ui_in[0].t0 VGND.t59 VGND.t23 sg13_lv_nmos ad=0.19p pd=1.38u as=0.19p ps=1.38u w=1u l=1u
X49 analog_1 analog_0 VAPWR VAPWR sg13_lv_pmos ad=1.14p pd=6.38u as=1.14p ps=6.38u w=6u l=1u
X50 VGND.t63 ui_in[0].t0 analog_2 VGND.t27 sg13_lv_nmos ad=0.19p pd=1.38u as=0.19p ps=1.38u w=1u l=1u
X51 analog_1 analog_0 VGND.t16 VGND.t17 sg13_lv_nmos ad=0.19p pd=1.38u as=0.19p ps=1.38u w=1u l=1u
X52 VAPWR analog_0 analog_1 VAPWR sg13_lv_pmos ad=1.14p pd=6.38u as=1.14p ps=6.38u w=6u l=1u
X53 analog_1 analog_0 VAPWR VAPWR sg13_lv_pmos ad=1.14p pd=6.38u as=1.14p ps=6.38u w=6u l=1u
X54 VAPWR ui_in[0].t1 analog_2 VAPWR sg13_lv_pmos ad=1.14p pd=6.38u as=1.14p ps=6.38u w=6u l=1u
X55 VGND.t22 analog_0 analog_1 VGND.t21 sg13_lv_nmos ad=0.19p pd=1.38u as=0.19p ps=1.38u w=1u l=1u
X56 analog_1 analog_0 VAPWR VAPWR sg13_lv_pmos ad=1.14p pd=6.38u as=1.14p ps=6.38u w=6u l=1u
X57 analog_1 analog_0 VAPWR VAPWR sg13_lv_pmos ad=1.14p pd=6.38u as=1.14p ps=6.38u w=6u l=1u
X58 analog_2 ui_in[0].t1 VAPWR VAPWR sg13_lv_pmos ad=1.14p pd=6.38u as=1.14p ps=6.38u w=6u l=1u
X59 VGND.t65 ui_in[0].t0 analog_2 VGND.t30 sg13_lv_nmos ad=0.19p pd=1.38u as=0.19p ps=1.38u w=1u l=1u
X60 analog_1 analog_0 VGND.t19 VGND.t20 sg13_lv_nmos ad=0.19p pd=1.38u as=0.19p ps=1.38u w=1u l=1u
X61 VAPWR VAPWR VAPWR VAPWR sg13_lv_pmos ad=2.04p pd=12.68u as=0 ps=0 w=6u l=1u
X62 VGND.t42 VGND.t39 VGND.t41 VGND.t40 sg13_lv_nmos ad=0.19p pd=1.38u as=0 ps=0 w=1u l=1u
X63 VGND.t25 analog_0 analog_1 VGND.t24 sg13_lv_nmos ad=0.19p pd=1.38u as=0.19p ps=1.38u w=1u l=1u
X64 analog_1 analog_0 VGND.t31 VGND.t32 sg13_lv_nmos ad=0.19p pd=1.38u as=0.19p ps=1.38u w=1u l=1u
X65 VGND.t45 VGND.t43 VGND.t5 VGND.t36 sg13_lv_nmos ad=0.34p pd=2.68u as=0 ps=0 w=1u l=1u
X66 analog_1 analog_0 VGND.t10 VGND.t11 sg13_lv_nmos ad=0.19p pd=1.38u as=0.19p ps=1.38u w=1u l=1u
X67 analog_1 analog_0 VGND.t28 VGND.t29 sg13_lv_nmos ad=0.19p pd=1.38u as=0.19p ps=1.38u w=1u l=1u
X68 analog_2 ui_in[0].t1 VAPWR VAPWR sg13_lv_pmos ad=1.14p pd=6.38u as=1.14p ps=6.38u w=6u l=1u
X69 VAPWR ui_in[0].t1 analog_2 VAPWR sg13_lv_pmos ad=1.14p pd=6.38u as=1.14p ps=6.38u w=6u l=1u
X70 VGND.t49 ui_in[0].t0 analog_2 VGND.t6 sg13_lv_nmos ad=0.19p pd=1.38u as=0.19p ps=1.38u w=1u l=1u
X71 VAPWR ui_in[0].t1 analog_2 VAPWR sg13_lv_pmos ad=1.14p pd=6.38u as=1.14p ps=6.38u w=6u l=1u
X72 VAPWR ui_in[0].t1 analog_2 VAPWR sg13_lv_pmos ad=1.14p pd=6.38u as=1.14p ps=6.38u w=6u l=1u
X73 analog_2 ui_in[0].t0 VGND.t53 VGND.t14 sg13_lv_nmos ad=0.19p pd=1.38u as=0.19p ps=1.38u w=1u l=1u
X74 VAPWR ui_in[0].t1 analog_2 VAPWR sg13_lv_pmos ad=1.14p pd=6.38u as=1.14p ps=6.38u w=6u l=1u
X75 analog_2 ui_in[0].t1 VAPWR VAPWR sg13_lv_pmos ad=1.14p pd=6.38u as=1.14p ps=6.38u w=6u l=1u
X76 analog_2 ui_in[0].t0 VGND.t55 VGND.t17 sg13_lv_nmos ad=0.19p pd=1.38u as=0.19p ps=1.38u w=1u l=1u
X77 analog_2 ui_in[0].t1 VAPWR VAPWR sg13_lv_pmos ad=1.14p pd=6.38u as=1.14p ps=6.38u w=6u l=1u
X78 VGND.t59 ui_in[0].t0 analog_2 VGND.t21 sg13_lv_nmos ad=0.19p pd=1.38u as=0.19p ps=1.38u w=1u l=1u
X79 VAPWR analog_0 analog_1 VAPWR sg13_lv_pmos ad=1.14p pd=6.38u as=1.14p ps=6.38u w=6u l=1u
X80 VAPWR ui_in[0].t1 analog_2 VAPWR sg13_lv_pmos ad=1.14p pd=6.38u as=1.14p ps=6.38u w=6u l=1u
X81 analog_2 ui_in[0].t0 VGND.t57 VGND.t20 sg13_lv_nmos ad=0.19p pd=1.38u as=0.19p ps=1.38u w=1u l=1u
X82 analog_1 analog_0 VAPWR VAPWR sg13_lv_pmos ad=1.14p pd=6.38u as=1.14p ps=6.38u w=6u l=1u
X83 VGND.t61 ui_in[0].t0 analog_2 VGND.t24 sg13_lv_nmos ad=0.19p pd=1.38u as=0.19p ps=1.38u w=1u l=1u
X84 analog_2 ui_in[0].t0 VGND.t65 VGND.t32 sg13_lv_nmos ad=0.19p pd=1.38u as=0.19p ps=1.38u w=1u l=1u
X85 VGND.t3 VAPWR VGND.t3 VGND.t2 sg13_lv_pmos ad=3.4p pd=20.68u as=0 ps=0 w=10u l=10u
X86 VAPWR ui_in[0].t1 analog_2 VAPWR sg13_lv_pmos ad=1.14p pd=6.38u as=1.14p ps=6.38u w=6u l=1u
X87 analog_2 ui_in[0].t0 VGND.t51 VGND.t11 sg13_lv_nmos ad=0.19p pd=1.38u as=0.19p ps=1.38u w=1u l=1u
X88 analog_2 ui_in[0].t0 VGND.t63 VGND.t29 sg13_lv_nmos ad=0.19p pd=1.38u as=0.19p ps=1.38u w=1u l=1u
X89 VGND.t34 analog_0 analog_1 VGND.t33 sg13_lv_nmos ad=0.19p pd=1.38u as=0.19p ps=1.38u w=1u l=1u
R0 ui_in[0].n15 ui_in[0].t1 0.994683
R1 ui_in[0].n17 ui_in[0].t0 0.994013
R2 ui_in[0].n9 ui_in[0].n1 0.748572
R3 ui_in[0].n10 ui_in[0].n9 0.578786
R4 ui_in[0].n11 ui_in[0].n10 0.578786
R5 ui_in[0].n12 ui_in[0].n11 0.578786
R6 ui_in[0].n13 ui_in[0].n12 0.578786
R7 ui_in[0].n14 ui_in[0].n13 0.578786
R8 ui_in[0].n15 ui_in[0].n14 0.578786
R9 ui_in[0].n0 ui_in[0].n24 0.755676
R10 ui_in[0].n24 ui_in[0].n23 0.578786
R11 ui_in[0].n23 ui_in[0].n22 0.578786
R12 ui_in[0].n22 ui_in[0].n21 0.578786
R13 ui_in[0].n21 ui_in[0].n20 0.578786
R14 ui_in[0].n20 ui_in[0].n19 0.578786
R15 ui_in[0].n19 ui_in[0].n18 0.578786
R16 ui_in[0].n18 ui_in[0].n17 0.578786
R17 ui_in[0].n14 ui_in[0].n8 0.254024
R18 ui_in[0].n13 ui_in[0].n7 0.254024
R19 ui_in[0].n12 ui_in[0].n6 0.254024
R20 ui_in[0].n11 ui_in[0].n5 0.254024
R21 ui_in[0].n10 ui_in[0].n4 0.254024
R22 ui_in[0].n9 ui_in[0].n3 0.254024
R23 ui_in[0].n1 ui_in[0].n2 0.0282822
R24 ui_in[0].n24 ui_in[0].n2 0.254024
R25 ui_in[0].n23 ui_in[0].n3 0.254024
R26 ui_in[0].n22 ui_in[0].n4 0.254024
R27 ui_in[0].n21 ui_in[0].n5 0.254024
R28 ui_in[0].n20 ui_in[0].n6 0.254024
R29 ui_in[0].n19 ui_in[0].n7 0.254024
R30 ui_in[0].n18 ui_in[0].n8 0.254024
R31 ui_in[0].n17 ui_in[0].n16 0.192615
R32 ui_in[0].n16 ui_in[0].n15 0.191641
R33 ui_in[0].n16 ui_in[0].n8 0.128842
R34 ui_in[0].n1 ui_in[0].n0 0.105962
R35 ui_in[0].n3 ui_in[0].n2 0.12194
R36 ui_in[0].n4 ui_in[0].n3 0.12194
R37 ui_in[0].n5 ui_in[0].n4 0.12194
R38 ui_in[0].n6 ui_in[0].n5 0.12194
R39 ui_in[0].n7 ui_in[0].n6 0.12194
R40 ui_in[0].n8 ui_in[0].n7 0.12194
R41 ui_in[0] ui_in[0].n0 40.295
R42 VGND.n117 VGND.t4 86.957
R43 VGND.t33 VGND.n97 86.957
R44 VGND.n118 VGND.t6 81.5222
R45 VGND.t32 VGND.n98 81.5222
R46 VGND.n119 VGND.t8 76.0875
R47 VGND.t30 VGND.n99 76.0875
R48 VGND.n120 VGND.t9 70.6527
R49 VGND.t29 VGND.n100 70.6527
R50 VGND.n121 VGND.t11 65.2179
R51 VGND.t27 VGND.n101 65.2179
R52 VGND.n122 VGND.t12 59.7831
R53 VGND.t26 VGND.n102 59.7831
R54 VGND.n123 VGND.t14 54.3483
R55 VGND.t18 VGND.n107 54.3483
R56 VGND.n127 VGND.t20 54.3483
R57 VGND.t24 VGND.n103 54.3483
R58 VGND.n124 VGND.t15 48.9135
R59 VGND.t17 VGND.n108 48.9135
R60 VGND.n128 VGND.t21 48.9135
R61 VGND.t23 VGND.n104 48.9135
R62 VGND.t15 VGND.n109 43.4788
R63 VGND.n125 VGND.t17 43.4788
R64 VGND.t21 VGND.n105 43.4788
R65 VGND.n129 VGND.t23 43.4788
R66 VGND.t14 VGND.n110 38.044
R67 VGND.n126 VGND.t18 38.044
R68 VGND.t20 VGND.n106 38.044
R69 VGND.n130 VGND.t24 38.044
R70 VGND.t12 VGND.n111 32.6092
R71 VGND.n131 VGND.t26 32.6092
R72 VGND.t11 VGND.n112 27.1744
R73 VGND.n132 VGND.t27 27.1744
R74 VGND.t9 VGND.n113 21.7396
R75 VGND.n133 VGND.t29 21.7396
R76 VGND.n7 VGND.n16 1.80852
R77 VGND.n7 VGND.n147 17.0005
R78 VGND.n7 VGND.n11 0.661826
R79 VGND.n11 VGND.n50 14.3607
R80 VGND.n7 VGND.n28 0.661826
R81 VGND.n7 VGND.n181 17.0005
R82 VGND.n28 VGND.n77 14.3607
R83 VGND.n7 VGND.n149 17.0005
R84 VGND.n7 VGND.n31 0.661826
R85 VGND.n31 VGND.n51 14.36
R86 VGND.n18 VGND.n79 14.3607
R87 VGND.n7 VGND.n99 8.49894
R88 VGND.n6 VGND.n5 0.0146543
R89 VGND.n29 VGND.n54 14.3607
R90 VGND.n21 VGND.n80 14.36
R91 VGND.n7 VGND.n41 4.24728
R92 VGND.n7 VGND.n21 0.661826
R93 VGND.n7 VGND.n101 8.49902
R94 VGND.n7 VGND.n32 0.661826
R95 VGND.n32 VGND.n56 14.36
R96 VGND.n7 VGND.n131 8.49663
R97 VGND.n7 VGND.n12 0.661826
R98 VGND.n7 VGND.n176 17.0005
R99 VGND.n12 VGND.n82 14.3607
R100 VGND.n7 VGND.n103 8.49966
R101 VGND.n7 VGND.n30 0.661826
R102 VGND.n30 VGND.n59 14.36
R103 VGND.n7 VGND.n8 0.661826
R104 VGND.n8 VGND.n83 14.3607
R105 VGND.n7 VGND.n154 17.0005
R106 VGND.n7 VGND.n25 0.661826
R107 VGND.n25 VGND.n62 14.36
R108 VGND.n7 VGND.n127 8.50002
R109 VGND.n7 VGND.n40 4.24736
R110 VGND.n15 VGND.n85 14.5797
R111 VGND.n7 VGND.n107 8.49954
R112 VGND.n26 VGND.n86 14.3607
R113 VGND.n7 VGND.n172 17.0005
R114 VGND.n22 VGND.n65 14.36
R115 VGND.n7 VGND.n155 17.0005
R116 VGND.n7 VGND.n124 8.4998
R117 VGND.n7 VGND.n27 0.661826
R118 VGND.n27 VGND.n87 14.3607
R119 VGND.n7 VGND.n167 17.0005
R120 VGND.n7 VGND.n10 0.661826
R121 VGND.n7 VGND.n156 17.0005
R122 VGND.n24 VGND.n88 14.3607
R123 VGND.n7 VGND.n112 8.49813
R124 VGND.n19 VGND.n70 14.36
R125 VGND.n7 VGND.n48 5.66316
R126 VGND.n7 VGND.n19 0.661826
R127 VGND.n7 VGND.n157 17.0005
R128 VGND.n13 VGND.n89 14.36
R129 VGND.n7 VGND.n13 0.661826
R130 VGND.n14 VGND.n90 14.36
R131 VGND.n7 VGND.n14 0.661826
R132 VGND.n7 VGND.n44 4.2472
R133 VGND.n23 VGND.n74 14.36
R134 VGND.n7 VGND.n117 8.49976
R135 VGND.n7 VGND.n161 17.0005
R136 VGND.n17 VGND.n75 14.36
R137 VGND.n7 VGND.n20 0.661826
R138 VGND.n20 VGND.t36 7.18026
R139 VGND.n7 VGND.n9 1.80841
R140 VGND.n95 VGND.n183 17.0005
R141 VGND.n95 VGND.n212 17.0005
R142 VGND.n95 VGND.n38 2.4234
R143 VGND.n95 VGND.n5 17.0005
R144 VGND.n95 VGND.n187 17.0005
R145 VGND.n95 VGND.n207 17.0005
R146 VGND.n95 VGND.n47 5.66421
R147 VGND.n95 VGND.n35 2.41714
R148 VGND.n95 VGND.n193 17.0005
R149 VGND.n95 VGND.n93 17.0005
R150 VGND.n7 VGND.n136 8.49566
R151 VGND.n7 VGND.n97 8.48987
R152 VGND.n7 VGND.n135 8.49542
R153 VGND.n7 VGND.n98 8.4901
R154 VGND.n7 VGND.n134 8.49517
R155 VGND.n7 VGND.n133 8.49492
R156 VGND.n7 VGND.n100 8.49034
R157 VGND.n7 VGND.n132 8.49688
R158 VGND.n7 VGND.n102 8.49058
R159 VGND.n7 VGND.n130 8.49468
R160 VGND.n7 VGND.n129 8.49877
R161 VGND.n7 VGND.n104 8.49081
R162 VGND.n7 VGND.n128 8.49443
R163 VGND.n7 VGND.n105 8.49919
R164 VGND.n7 VGND.n106 8.49105
R165 VGND.n7 VGND.n126 8.49419
R166 VGND.n7 VGND.n125 8.49395
R167 VGND.n7 VGND.n108 8.49129
R168 VGND.n7 VGND.n109 8.49153
R169 VGND.n7 VGND.n123 8.4937
R170 VGND.n7 VGND.n110 8.49638
R171 VGND.n7 VGND.n122 8.49857
R172 VGND.n7 VGND.n111 8.49984
R173 VGND.n7 VGND.n121 8.49346
R174 VGND.n7 VGND.n120 8.49321
R175 VGND.n7 VGND.n113 8.49177
R176 VGND.n7 VGND.n119 8.49297
R177 VGND.n7 VGND.n114 8.49201
R178 VGND.n7 VGND.n118 8.49273
R179 VGND.n7 VGND.n115 8.49225
R180 VGND.n7 VGND.n116 8.49249
R181 VGND.t8 VGND.n114 16.3048
R182 VGND.n134 VGND.t30 16.3048
R183 VGND.t35 VGND.n146 15.0005
R184 VGND.n229 VGND.t46 15.0005
R185 VGND.n218 VGND.t39 15.0005
R186 VGND.n235 VGND.t43 15.0005
R187 VGND.n15 VGND.n84 14.5797
R188 VGND.n11 VGND.t40 7.18094
R189 VGND.n29 VGND.n53 14.3607
R190 VGND.n26 VGND.n63 14.3607
R191 VGND.n22 VGND.n64 14.3607
R192 VGND.n24 VGND.n69 14.3607
R193 VGND.n23 VGND.n91 14.3607
R194 VGND.n17 VGND.n92 14.3607
R195 VGND.n14 VGND.n73 14.3614
R196 VGND.n13 VGND.n72 14.3614
R197 VGND.n19 VGND.n71 14.3614
R198 VGND.n10 VGND.n68 14.3614
R199 VGND.n21 VGND.n81 14.3614
R200 VGND.t6 VGND.n115 10.8701
R201 VGND.n135 VGND.t32 10.8701
R202 VGND.n16 VGND.n95 0.0773423
R203 VGND.n96 VGND.n95 0.00286578
R204 VGND.n7 VGND.n182 8.4984
R205 VGND.n7 VGND.n148 8.4984
R206 VGND.n7 VGND.n180 8.4984
R207 VGND.n37 VGND.n38 0.00653337
R208 VGND.n5 VGND.n37 0.00867464
R209 VGND.n7 VGND.n6 2.11119
R210 VGND.n41 VGND.n211 0.0180745
R211 VGND.n7 VGND.n179 8.4984
R212 VGND.n7 VGND.n178 8.4984
R213 VGND.n7 VGND.n177 8.4984
R214 VGND.n7 VGND.n150 8.4984
R215 VGND.n7 VGND.n151 8.4984
R216 VGND.n7 VGND.n152 8.4984
R217 VGND.n7 VGND.n153 8.4984
R218 VGND.n7 VGND.n175 8.4984
R219 VGND.n7 VGND.n174 8.4984
R220 VGND.n40 VGND.n189 0.0180744
R221 VGND.n7 VGND.n34 4.24677
R222 VGND.n7 VGND.n173 8.4984
R223 VGND.n7 VGND.n170 8.4984
R224 VGND.n7 VGND.n169 8.4984
R225 VGND.n7 VGND.n168 8.4984
R226 VGND.n7 VGND.n165 8.4984
R227 VGND.n7 VGND.n164 8.4984
R228 VGND.n7 VGND.n163 8.4984
R229 VGND.n48 VGND.n46 0.00635632
R230 VGND.n7 VGND.n36 4.24695
R231 VGND.n7 VGND.n162 8.4984
R232 VGND.n7 VGND.n158 8.4984
R233 VGND.n7 VGND.n159 8.4984
R234 VGND.n7 VGND.n160 8.4984
R235 VGND.n95 VGND.n214 8.4984
R236 VGND.n95 VGND.n213 8.4984
R237 VGND.n95 VGND.n184 8.4984
R238 VGND.n95 VGND.n211 8.4984
R239 VGND.n43 VGND.n42 0.0123712
R240 VGND.n95 VGND.n43 4.24427
R241 VGND.n95 VGND.n210 8.4984
R242 VGND.n95 VGND.n185 8.4984
R243 VGND.n95 VGND.n186 8.4984
R244 VGND.n95 VGND.n188 8.4984
R245 VGND.n95 VGND.n209 8.4984
R246 VGND.n95 VGND.n208 8.4984
R247 VGND.n95 VGND.n205 8.4984
R248 VGND.n95 VGND.n204 8.4984
R249 VGND.n95 VGND.n189 8.4984
R250 VGND.n34 VGND.t57 0.0214465
R251 VGND.n33 VGND.n34 0.0197262
R252 VGND.n95 VGND.n33 2.11068
R253 VGND.n95 VGND.n190 8.4984
R254 VGND.n95 VGND.n191 8.4984
R255 VGND.n95 VGND.n203 8.4984
R256 VGND.n95 VGND.n202 8.4984
R257 VGND.n95 VGND.n201 8.4984
R258 VGND.n95 VGND.n200 8.4984
R259 VGND.n95 VGND.n199 8.4984
R260 VGND.n95 VGND.n198 8.4984
R261 VGND.n95 VGND.n197 8.4984
R262 VGND.n35 VGND.n36 0.0132723
R263 VGND.n36 VGND.n45 0.0188701
R264 VGND.n95 VGND.n192 8.4984
R265 VGND.n95 VGND.n196 8.4984
R266 VGND.n95 VGND.n194 8.4984
R267 VGND.n95 VGND.n195 8.4984
R268 VGND.n9 VGND.n95 0.0773271
R269 VGND.n232 VGND.t35 7.49606
R270 VGND.t46 VGND.n228 7.49606
R271 VGND.t39 VGND.n217 7.49606
R272 VGND.t43 VGND.n145 7.49606
R273 VGND.n78 VGND.n97 7.18094
R274 VGND.n53 VGND.n99 7.18094
R275 VGND.n80 VGND.n100 7.18094
R276 VGND.n55 VGND.n101 7.18094
R277 VGND.n58 VGND.n103 7.18094
R278 VGND.n61 VGND.n105 7.18094
R279 VGND.n84 VGND.n106 7.18094
R280 VGND.n63 VGND.n107 7.18094
R281 VGND.n64 VGND.n108 7.18094
R282 VGND.n69 VGND.n111 7.18094
R283 VGND.n70 VGND.n112 7.18094
R284 VGND.n89 VGND.n113 7.18094
R285 VGND.n90 VGND.n114 7.18094
R286 VGND.n91 VGND.n115 7.18094
R287 VGND.n92 VGND.n116 7.18094
R288 VGND.n75 VGND.n20 14.3614
R289 VGND.n74 VGND.n117 7.18094
R290 VGND.n67 VGND.n10 14.3607
R291 VGND.n66 VGND.n27 14.3614
R292 VGND.n65 VGND.n124 7.18094
R293 VGND.n62 VGND.n127 7.18094
R294 VGND.n60 VGND.n8 14.3614
R295 VGND.n59 VGND.n129 7.18094
R296 VGND.n57 VGND.n12 14.3614
R297 VGND.n56 VGND.n131 7.18094
R298 VGND.n52 VGND.n18 14.3614
R299 VGND.n51 VGND.n135 7.18094
R300 VGND.n16 VGND.t40 7.74158
R301 VGND.n50 VGND.n28 14.3607
R302 VGND.n77 VGND.n136 7.18026
R303 VGND.n78 VGND.n31 14.3607
R304 VGND.n79 VGND.n134 7.18026
R305 VGND.n54 VGND.n133 7.18026
R306 VGND.n81 VGND.n132 7.18026
R307 VGND.n55 VGND.n32 14.3607
R308 VGND.n82 VGND.n130 7.18026
R309 VGND.n58 VGND.n30 14.3607
R310 VGND.n83 VGND.n128 7.18026
R311 VGND.n61 VGND.n25 14.3607
R312 VGND.n85 VGND.n126 7.18026
R313 VGND.n86 VGND.n125 7.18026
R314 VGND.n87 VGND.n123 7.18026
R315 VGND.n68 VGND.n122 7.18026
R316 VGND.n88 VGND.n121 7.18026
R317 VGND.n71 VGND.n120 7.18026
R318 VGND.n72 VGND.n119 7.18026
R319 VGND.n73 VGND.n118 7.18026
R320 VGND.n52 VGND.n98 7.18026
R321 VGND.n57 VGND.n102 7.18026
R322 VGND.n60 VGND.n104 7.18026
R323 VGND.n66 VGND.n109 7.18026
R324 VGND.n67 VGND.n110 7.18026
R325 VGND.t1 VGND.t0 0.653035
R326 VGND.t4 VGND.n116 5.43528
R327 VGND.n136 VGND.t33 5.43528
R328 VGND.t5 VGND.n144 4.5005
R329 VGND.n233 VGND.t37 4.5005
R330 VGND.n230 VGND.t34 4.5005
R331 VGND.t42 VGND.n216 4.5005
R332 VGND.n95 VGND.n76 4.25219
R333 VGND.n95 VGND.n94 4.25206
R334 VGND.n7 VGND.n94 4.25175
R335 VGND.n7 VGND.n76 4.25169
R336 VGND.n237 VGND.n236 3.0005
R337 VGND.n231 VGND.n143 3.0005
R338 VGND.n227 VGND.n226 3.0005
R339 VGND.n220 VGND.n219 3.0005
R340 VGND.n239 VGND.t7 2.48177
R341 VGND.n240 VGND.t10 2.48177
R342 VGND.n241 VGND.t13 2.48177
R343 VGND.n142 VGND.t16 2.48177
R344 VGND.t22 VGND.n141 2.48177
R345 VGND.n222 VGND.t25 2.48177
R346 VGND.n223 VGND.t28 2.48177
R347 VGND.n224 VGND.t31 2.48177
R348 VGND.n239 VGND.t49 2.48177
R349 VGND.n240 VGND.t51 2.48177
R350 VGND.n241 VGND.t53 2.48177
R351 VGND.n142 VGND.t55 2.48177
R352 VGND.t59 VGND.n141 2.48177
R353 VGND.n222 VGND.t61 2.48177
R354 VGND.n223 VGND.t63 2.48177
R355 VGND.n224 VGND.t65 2.48177
R356 VGND.n7 VGND.n18 0.661826
R357 VGND.n7 VGND.n29 0.661826
R358 VGND.n7 VGND.n26 0.661826
R359 VGND.n7 VGND.n22 0.661826
R360 VGND.n7 VGND.n24 0.661826
R361 VGND.n7 VGND.n23 0.661826
R362 VGND.n7 VGND.n17 0.661826
R363 VGND.t45 VGND.n144 2.2505
R364 VGND.t38 VGND.n233 2.2505
R365 VGND.t47 VGND.n230 2.2505
R366 VGND.n216 VGND.t41 2.2505
R367 VGND.n7 VGND.n15 0.552335
R368 VGND VGND.n242 1.88203
R369 VGND.n242 VGND.n39 1.49725
R370 VGND.n95 VGND.n50 0.661826
R371 VGND.n95 VGND.n51 0.661826
R372 VGND.n95 VGND.n52 0.661826
R373 VGND.n95 VGND.n53 0.661826
R374 VGND.n95 VGND.n54 0.661826
R375 VGND.n95 VGND.n55 0.661826
R376 VGND.n95 VGND.n56 0.661826
R377 VGND.n95 VGND.n57 0.661826
R378 VGND.n95 VGND.n58 0.661826
R379 VGND.n95 VGND.n59 0.661826
R380 VGND.n95 VGND.n60 0.661826
R381 VGND.n95 VGND.n61 0.661826
R382 VGND.n95 VGND.n62 0.661826
R383 VGND.n95 VGND.n63 0.661826
R384 VGND.n95 VGND.n64 0.661826
R385 VGND.n95 VGND.n65 0.661826
R386 VGND.n95 VGND.n66 0.661826
R387 VGND.n95 VGND.n67 0.661826
R388 VGND.n95 VGND.n68 0.661826
R389 VGND.n95 VGND.n69 0.661826
R390 VGND.n95 VGND.n70 0.661826
R391 VGND.n95 VGND.n71 0.661826
R392 VGND.n95 VGND.n72 0.661826
R393 VGND.n95 VGND.n73 0.661826
R394 VGND.n95 VGND.n74 0.661826
R395 VGND.n95 VGND.n75 0.661826
R396 VGND.n9 VGND.t36 7.74092
R397 VGND.n95 VGND.n77 0.661826
R398 VGND.n95 VGND.n78 0.661826
R399 VGND.n95 VGND.n79 0.661826
R400 VGND.n95 VGND.n80 0.661826
R401 VGND.n95 VGND.n81 0.661826
R402 VGND.n95 VGND.n82 0.661826
R403 VGND.n95 VGND.n83 0.661826
R404 VGND.n95 VGND.n84 0.661826
R405 VGND.n95 VGND.n85 0.661826
R406 VGND.n95 VGND.n86 0.661826
R407 VGND.n95 VGND.n87 0.661826
R408 VGND.n95 VGND.n88 0.661826
R409 VGND.n95 VGND.n89 0.661826
R410 VGND.n95 VGND.n90 0.661826
R411 VGND.n95 VGND.n91 0.661826
R412 VGND.n95 VGND.n92 0.661826
R413 VGND.n49 VGND.t3 0.412464
R414 VGND.n3 VGND.n0 0.209311
R415 VGND.n4 VGND.n3 0.109949
R416 VGND.n140 VGND.n0 0.00335118
R417 VGND.n4 VGND.n1 0.411619
R418 VGND.n139 VGND.n138 0.409591
R419 VGND.n140 VGND.n137 0.409591
R420 VGND.n0 VGND.n49 0.412459
R421 VGND.t2 VGND.t3 0.653539
R422 VGND.n242 VGND.n3 1.46462
R423 VGND.n45 VGND.t49 0.200997
R424 VGND.n46 VGND.t51 0.200997
R425 VGND.n166 VGND.t53 0.200997
R426 VGND.n171 VGND.t55 0.200997
R427 VGND.n206 VGND.t59 0.200997
R428 VGND.t61 VGND.n221 0.200997
R429 VGND.t63 VGND.n42 0.200997
R430 VGND.t65 VGND.n37 0.200997
R431 VGND.n45 VGND.t7 0.200995
R432 VGND.n46 VGND.t10 0.200995
R433 VGND.n166 VGND.t13 0.200995
R434 VGND.n171 VGND.t16 0.200995
R435 VGND.n206 VGND.t22 0.200995
R436 VGND.n221 VGND.t25 0.200995
R437 VGND.n42 VGND.t28 0.200995
R438 VGND.n37 VGND.t31 0.200995
R439 VGND.t57 VGND.t19 0.185126
R440 VGND.n239 VGND.n238 0.117247
R441 VGND.n225 VGND.n224 0.1171
R442 VGND.n240 VGND.n239 0.08146
R443 VGND.n241 VGND.n240 0.08146
R444 VGND.n142 VGND.n241 0.08146
R445 VGND.n39 VGND.n142 0.08146
R446 VGND.n39 VGND.n141 0.08146
R447 VGND.n222 VGND.n141 0.08146
R448 VGND.n223 VGND.n222 0.08146
R449 VGND.n224 VGND.n223 0.08146
R450 VGND.t47 VGND.n96 1.03875
R451 VGND.t38 VGND.n7 1.05899
R452 VGND.t37 VGND.n232 0.031258
R453 VGND.n145 VGND.t5 0.031258
R454 VGND.n238 VGND.n237 0.0291125
R455 VGND.n238 VGND.n143 0.0291125
R456 VGND.n225 VGND.n220 0.0291125
R457 VGND.n226 VGND.n225 0.0291125
R458 VGND.n237 VGND.n144 0.0281144
R459 VGND.n233 VGND.n143 0.0281144
R460 VGND.n220 VGND.n216 0.0281144
R461 VGND.n230 VGND.n226 0.0281144
R462 VGND.n228 VGND.n215 0.0216549
R463 VGND.n217 VGND.n215 0.0216549
R464 VGND.t34 VGND.n229 0.0208704
R465 VGND.n218 VGND.t42 0.0208704
R466 VGND.n231 VGND.n146 0.0202884
R467 VGND.n229 VGND.n227 0.0202884
R468 VGND.n219 VGND.n218 0.0202884
R469 VGND.n236 VGND.n235 0.0202884
R470 VGND.t57 VGND.n39 0.0194533
R471 VGND.n215 VGND.n94 0.0162424
R472 VGND.n234 VGND.n76 0.0159649
R473 VGND.n213 VGND.n182 0.0118857
R474 VGND.n184 VGND.n148 0.0118857
R475 VGND.n38 VGND.n180 0.0262321
R476 VGND.n211 VGND.n6 0.0534527
R477 VGND.n42 VGND.n41 0.00668928
R478 VGND.n210 VGND.n179 0.0118857
R479 VGND.n185 VGND.n177 0.0118857
R480 VGND.n188 VGND.n150 0.0118857
R481 VGND.n209 VGND.n152 0.0118857
R482 VGND.n208 VGND.n153 0.0118857
R483 VGND.n204 VGND.n175 0.0118857
R484 VGND.n191 VGND.n170 0.0118857
R485 VGND.n203 VGND.n170 0.0118857
R486 VGND.n202 VGND.n169 0.0118857
R487 VGND.n201 VGND.n168 0.0118857
R488 VGND.n199 VGND.n165 0.0118857
R489 VGND.n198 VGND.n164 0.0118857
R490 VGND.n197 VGND.n163 0.0118857
R491 VGND.n47 VGND.n46 0.00858771
R492 VGND.n45 VGND.n44 0.00668917
R493 VGND.n192 VGND.n162 0.0118857
R494 VGND.n196 VGND.n162 0.0118857
R495 VGND.n194 VGND.n158 0.0118857
R496 VGND.n195 VGND.n159 0.0118857
R497 VGND.n195 VGND.n160 0.0118857
R498 VGND.n194 VGND.n159 0.0118857
R499 VGND.n192 VGND.n44 0.0180746
R500 VGND.n198 VGND.n163 0.0118857
R501 VGND.n199 VGND.n164 0.0118857
R502 VGND.n200 VGND.n165 0.0118857
R503 VGND.n202 VGND.n168 0.0118857
R504 VGND.n203 VGND.n169 0.0118857
R505 VGND.n190 VGND.n173 0.0118857
R506 VGND.n33 VGND.n173 0.0481046
R507 VGND.t57 VGND.n40 0.00668938
R508 VGND.n189 VGND.n174 0.0118857
R509 VGND.n204 VGND.n174 0.0118857
R510 VGND.n205 VGND.n175 0.0118857
R511 VGND.n208 VGND.n152 0.0118857
R512 VGND.n209 VGND.n151 0.0118857
R513 VGND.n188 VGND.n151 0.0118857
R514 VGND.n186 VGND.n177 0.0118857
R515 VGND.n185 VGND.n178 0.0118857
R516 VGND.n210 VGND.n178 0.0118857
R517 VGND.n43 VGND.n179 0.0237569
R518 VGND.n214 VGND.n182 0.0118857
R519 VGND.n234 VGND.n146 0.0115582
R520 VGND.n235 VGND.n234 0.0115582
R521 VGND.n193 VGND.n161 0.0108889
R522 VGND.n35 VGND.n157 0.0461529
R523 VGND.n212 VGND.n149 0.0108889
R524 VGND.n183 VGND.n181 0.0108889
R525 VGND.n232 VGND.n231 0.0108877
R526 VGND.n228 VGND.n227 0.0108877
R527 VGND.n219 VGND.n217 0.0108877
R528 VGND.n236 VGND.n145 0.0108877
R529 VGND.t47 VGND.n215 0.0101032
R530 VGND.t41 VGND.n215 0.0101032
R531 VGND.n234 VGND.t38 0.00981217
R532 VGND.n234 VGND.t45 0.00981217
R533 VGND.n167 VGND.n166 0.00691667
R534 VGND.n221 VGND.n187 0.00691667
R535 VGND.t1 VGND.n2 0.423503
R536 VGND.n2 VGND.n1 0.0160967
R537 VGND.n1 VGND.n138 0.00643258
R538 VGND.n138 VGND.n137 0.00643258
R539 VGND.n137 VGND.n49 0.00643258
R540 VGND.n234 VGND.n93 0.00630556
R541 VGND.n207 VGND.n153 0.00619286
R542 VGND.n160 VGND.n93 0.00619286
R543 VGND.n214 VGND.n147 0.00619286
R544 VGND.n186 VGND.n176 0.00619286
R545 VGND.n205 VGND.n154 0.00619286
R546 VGND.n190 VGND.n172 0.00619286
R547 VGND.n200 VGND.n156 0.00619286
R548 VGND.n193 VGND.n158 0.00619286
R549 VGND.n196 VGND.n161 0.00619286
R550 VGND.n47 VGND.n157 0.0104858
R551 VGND.n197 VGND.n48 0.0174081
R552 VGND.n201 VGND.n167 0.00619286
R553 VGND.n191 VGND.n155 0.00619286
R554 VGND.n187 VGND.n150 0.00619286
R555 VGND.n212 VGND.n180 0.00619286
R556 VGND.n184 VGND.n149 0.00619286
R557 VGND.n183 VGND.n148 0.00619286
R558 VGND.n213 VGND.n181 0.00619286
R559 VGND.n215 VGND.n147 0.00615278
R560 VGND.n171 VGND.n155 0.00569444
R561 VGND.n172 VGND.n171 0.00569444
R562 VGND.n206 VGND.n154 0.00569444
R563 VGND.n207 VGND.n206 0.00569444
R564 VGND.n3 VGND.n2 0.101515
R565 VGND.n139 VGND.n4 0.0051722
R566 VGND.n140 VGND.n139 0.00524607
R567 VGND.n166 VGND.n156 0.00447222
R568 VGND.n221 VGND.n176 0.00447222
R569 VGND.n96 VGND.t45 1.08146
R570 VGND.n7 VGND.t41 1.07909
C0 VAPWR ui_in[0] 26.8581f
C1 VAPWR analog_1 11.1938f
C2 analog_0 ui_in[0] 0.12731f
C3 analog_0 analog_1 16.6419f
C4 VAPWR analog_2 11.144f
C5 ui_in[0] VPWR 0.54099f
C6 ui_in[0] analog_2 16.0232f
C7 analog_1 analog_2 0.72158f
C8 analog_0 VAPWR 26.7524f
C9 uo_out[0] VGND 0.04448f
C10 uo_out[1] VGND 0.03799f
C11 uo_out[2] VGND 0.03799f
C12 uo_out[3] VGND 0.03799f
C13 uo_out[4] VGND 0.03799f
C14 uo_out[5] VGND 0.03799f
C15 uo_out[6] VGND 0.03799f
C16 uo_out[7] VGND 0.03799f
C17 uio_out[0] VGND 0.03799f
C18 uio_out[1] VGND 0.03799f
C19 uio_out[2] VGND 0.03799f
C20 uio_out[3] VGND 0.03799f
C21 uio_out[4] VGND 0.03799f
C22 uio_out[5] VGND 0.03799f
C23 uio_out[6] VGND 0.03799f
C24 uio_out[7] VGND 0.03799f
C25 uio_oe[0] VGND 0.03799f
C26 uio_oe[1] VGND 0.03799f
C27 uio_oe[2] VGND 0.03799f
C28 uio_oe[3] VGND 0.03799f
C29 uio_oe[4] VGND 0.03799f
C30 uio_oe[5] VGND 0.03799f
C31 uio_oe[6] VGND 0.03799f
C32 uio_oe[7] VGND 0.03799f
C33 ui_in[1] VGND 0.03799f
C34 ui_in[2] VGND 0.03799f
C35 ui_in[3] VGND 0.03799f
C36 ui_in[4] VGND 0.03799f
C37 ui_in[5] VGND 0.03799f
C38 ui_in[6] VGND 0.03799f
C39 ui_in[7] VGND 0.03799f
C40 uio_in[0] VGND 0.03799f
C41 uio_in[1] VGND 0.03799f
C42 uio_in[2] VGND 0.03799f
C43 uio_in[3] VGND 0.03799f
C44 uio_in[4] VGND 0.03799f
C45 uio_in[5] VGND 0.03799f
C46 uio_in[6] VGND 0.03799f
C47 uio_in[7] VGND 0.03799f
C48 ena VGND 0.03799f
C49 clk VGND 0.03799f
C50 rst_n VGND 0.04448f
C51 analog_1 VGND 24.30245f
C52 analog_2 VGND 29.06621f
C53 ui_in[0] VGND 28.23714f
C54 VGND.t1 VGND 43.632f
C55 VGND.t5 VGND 11.71255f
C56 VGND.t42 VGND 3.09716f
C57 ui_in[0].n0 VGND 4.027f
C58 ui_in[0].n1 VGND 0.12143f
C59 ui_in[0].n2 VGND 0.23471f
C60 ui_in[0].n3 VGND 0.23471f
C61 ui_in[0].n4 VGND 0.23471f
C62 ui_in[0].n5 VGND 0.23471f
C63 ui_in[0].n6 VGND 0.23471f
C64 ui_in[0].n7 VGND 0.23471f
C65 ui_in[0].n8 VGND 0.24805f
C66 ui_in[0].n9 VGND 0.07136f
C67 ui_in[0].n10 VGND 0.05503f
C68 ui_in[0].n11 VGND 0.05503f
C69 ui_in[0].n12 VGND 0.05503f
C70 ui_in[0].n13 VGND 0.05503f
C71 ui_in[0].n14 VGND 0.05503f
C72 ui_in[0].n15 VGND 0.61403f
C73 ui_in[0].n16 VGND 2.46899f
C74 ui_in[0].n17 VGND 0.62395f
C75 ui_in[0].n18 VGND 0.05503f
C76 ui_in[0].n19 VGND 0.05503f
C77 ui_in[0].n20 VGND 0.05503f
C78 ui_in[0].n21 VGND 0.05503f
C79 ui_in[0].n22 VGND 0.05503f
C80 ui_in[0].n23 VGND 0.05503f
C81 ui_in[0].n24 VGND 0.0721f
.ends
